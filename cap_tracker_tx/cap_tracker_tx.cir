.title KiCad schematic
LEDR1 +5V Net-_LEDR1--_ YLED0603R
R9 Net-_U2-_STDBY_ Net-_LEDG1--_ 1k
R8 Net-_U2-_CHRG_ Net-_LEDR1--_ 1k
LEDG1 +5V Net-_LEDG1--_ YLED0603G
C3 +5V GND 10u
C4 GND USB_5V 100n
X2 __X2
C7 Net-_U1-Y_ /ENIG_Surface 100n
U1 __U1
R11 +3.3V SDA 2.2k
R12 +3.3V SCL 2.2k
Boot1 __Boot1
EN1 __EN1
U3 __U3
Q1 __Q1
R6 Net-_Q2-Pad1_ USB_5V 10k
Q2 __Q2
Q3 __Q3
R14 Net-_Q3-G_ USB_5V 100k
C2 +3.3V GND 100n
R5 GND USB_5V 100k
R7 Net-_Q1-S_ Net-_U2-TEMP_ NTC 5D-7
R4 Batt_Level Net-_Q1-S_ 100k
CN1 __CN1
R3 GND Net-_U2-TEMP_ 100k
C5 Net-_Q1-S_ Net-_U2-TEMP_ 10u
Battery1 __Battery1
R13 GND Net-_U2-PROG_ 1.2k
U2 __U2
R2 GND Net-_USB1-CC2_ 5.1k
R1 Net-_USB1-CC1_ GND 5.1k
USB1 __USB1
C6 EN GND 1u
R10 +3.3V EN 10k
U4 __U4
U6 __U6
C1 GND +3.3V 100n
U5 __U5
.end
